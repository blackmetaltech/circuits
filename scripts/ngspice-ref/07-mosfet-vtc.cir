* 07 NMOS inverter voltage-transfer curve (2N7000 with 1 kohm drain pull-up, Vdd 5 V).
* Analysis : DC sweep of Vin 0..5 V in 10 mV steps (501 rows).
* Outputs  : 07-mosfet-vtc.csv = vin_V, v_out_V, i_d_A (current from Vdd through the pull-up).
* CIRCUITS circuit: Vdd 5 V -> R 1k -> drain; 2N7000 gate = Vin, source = bulk = gnd; body diode source->drain (reverse-biased here).
* Parameters: 2N7000 Level-1 Vt 2.1 Kp 0.052743 (= 1/(2.4*7.9)) lambda 0.02, W=L=1, zero capacitances, GAMMA 0; DBODY estimate.
.include common.inc
Vdd vdd 0 5
Vin g 0 0
RD vdd d 1k
M1 d g 0 0 M2N7000 W=1 L=1
Db 0 d DBODY
.control
dc Vin 0 5 0.01
let i_d = -i(Vdd)
set wr_singlescale
set numdgt=8
wrdata build/07.dat v(d) i_d
.endc
.end
