* 09 series RLC step response (DESIGN 9.1 TR-03): 10 V step, 20 ohm, 10 mH, 10 uF; output = capacitor voltage.
* The step is the CIRCUITS power-on convention: a 1 us linear ramp 0 -> 10 V starting at t = 0 (DESIGN 3.5).
* Analysis : transient from zero state, t = 0..4.9975 ms (2.5 us grid, 2000 rows).
* Outputs  : 09-rlc-step.csv = time_s, v_in_V, v_cap_V, i_L_A.
* TR-03 (ideal step): zeta 0.31623, w0 3162.3 rad/s, overshoot 35.092 %, Vpk 13.509 V at 1.0472 ms.
* Parameters: R 20, L 10 mH, C 10 uF, all ideal (no ESR, no DCR).
.include common.inc
Vin in 0 PWL(0 0 1u 10)
R1 in a 20
L1 a b 10m
C1 b 0 10u
.control
tran 2.5u 4.9975m 0 0.5u uic
linearize v(in) v(b) i(L1)
set wr_singlescale
set numdgt=8
wrdata build/09.dat v(in) v(b) i(L1)
.endc
.end
