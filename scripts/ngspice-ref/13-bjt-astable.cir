* 13 BJT astable multivibrator (2x 2N3904), Vcc 9 V, RC 1k, RB 47k, C1 10 nF, C2 10.5 nF (5 % asymmetry makes the start-up side
* deterministic; a perfectly symmetric circuit started from zero never leaves its metastable point in exact arithmetic).
* Analysis : transient from zero state (uic), t = 0..9.995 ms (5 us grid, 2000 rows).
* Outputs  : 13-bjt-astable.csv = time_s, v_c1_V, v_c2_V, v_b1_V, v_b2_V.
* Analytic estimate: T = 0.693 * RB * (C1 + C2) = 0.6677 ms, f = 1497.7 Hz (the exact value is the reference: see README).
* Circuit  : Q1 c1,b1,gnd; Q2 c2,b2,gnd; RC1 Vcc-c1, RC2 Vcc-c2; RB1 Vcc-b1, RB2 Vcc-b2; C1 c1-b2; C2 c2-b1.
* Parameters: 2N3904 Is 6.734f Bf 200 Br 0.737 Vaf 74, Ebers-Moll, no capacitances. (B-E reverse breakdown is not modelled in either.)
.include common.inc
* Numerical aid: 1 pF from every node to ground. Without it ngspice (any method) fails with "timestep too small" when the
* floating, capacitance-free bridge nodes / regenerative BJT nodes switch. 1 pF is 1e-5 of the smallest real capacitor here, so it
* changes no result at the reference tolerance (checked against 0.1 pF; see README). CIRCUITS has no shunt capacitance: this is ngspice-only.
.options cshunt=1p
Vcc vcc 0 9
RC1 vcc c1 1k
RC2 vcc c2 1k
RB1 vcc b1 47k
RB2 vcc b2 47k
C1 c1 b2 10n
C2 c2 b1 10.5n
Q1 c1 b1 0 Q2N3904
Q2 c2 b2 0 Q2N3904
.control
tran 5u 9.995m 0 1u uic
linearize v(c1) v(c2) v(b1) v(b2)
set wr_singlescale
set numdgt=8
wrdata build/13.dat v(c1) v(c2) v(b1) v(b2)
.endc
.end
